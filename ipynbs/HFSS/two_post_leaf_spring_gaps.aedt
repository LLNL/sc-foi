# Ansys Electronics Desktop project, version 2024.2
materials:
  vacuum: permittivity=1
  sapphire: permittivity=10 dielectric_loss_tangent=1.9e-08

design two_post_leaf_spring_jj (HFSS, Eigenmode, model units mm)
variables:
  t_chip = 450um
  w_chip = 6mm
  l_chip = 28mm
  z_shift = 9.5mm
  chip_zoffset = 5.5mm
  l_taper = 0.25mm
  l_junc = 50um
  w_junc = 50um
  l_pad = w_chip/2 - l_taper - l_junc/2
  w_pad = 0.5mm
  LJ = 1nH
  t_ox = 3nm
  eps_al2o3 = 10
  lambdaL = 60nm
geometry:
  Solid2 = imported_body(Z:\tcav\inventor\two_post_cylindrical_coupler\two_post_cylindrical_coupler_leaf_springs.stp)
  Solid2.rotate(axis=X, angle=90deg)
  Solid2.move(0mm, 0mm, z_shift)
  cavity [vacuum] = cylinder(axis=Z, base_centre=(0mm, 0mm, 0mm), radius=13mm, height=84.5mm)
  cavity.subtract(Solid2)
  chip [sapphire] = box(corner=(-w_chip/2, -l_chip/2, chip_zoffset-t_chip), size=(w_chip, l_chip, t_chip))
  chip_1 = chip.copy()
  cavity.subtract(chip_1)
  l_pad = rectangle(corner=(-w_chip/2, -w_pad/2, chip_zoffset), x_size=l_pad, y_size=w_pad)
  l_pad_taper = rectangle(corner=(-l_junc/2-l_taper, -w_junc/2, chip_zoffset), x_size=l_taper, y_size=w_junc)
  jj = rectangle(corner=(-w_junc/2, -l_junc/2, chip_zoffset), x_size=w_junc, y_size=l_junc)
  r_pad_taper = rectangle(corner=(l_junc/2, -w_junc/2, chip_zoffset), x_size=l_taper, y_size=w_junc)
  r_pad = rectangle(corner=(l_taper+ l_junc/2, -w_pad/2, chip_zoffset), x_size=l_pad, y_size=w_pad)
  cavity_ObjectFromFace1 = object_from(cavity.face(at (7.98514, 0, 5)))
  cavity_ObjectFromFace2 = object_from(cavity.face(at (6.70752, 6.5, 5)))
  cavity_ObjectFromFace3 = object_from(cavity.face(at (6.70752, -6.5, 5)))
  cavity_ObjectFromFace4 = object_from(cavity.face(at (-6.70752, 6.5, 5)))
  cavity_ObjectFromFace5 = object_from(cavity.face(at (-7.98514, 0, 5)))
  cavity_ObjectFromFace6 = object_from(cavity.face(at (-6.70752, -6.5, 5)))
  cavity_ObjectFromFace4_ObjectFromFace1 = object_from(cavity_ObjectFromFace4.face)
  cavity_ObjectFromEdge1 = object_from(cavity.edge(at (-1, 0, 5.5)))
  l_pad_ObjectFromEdge1..l_pad_ObjectFromEdge4 = object_from(l_pad.edge(all 4))
  cavity_ObjectFromEdge1.subtract(l_pad_ObjectFromEdge1..l_pad_ObjectFromEdge4)
  cavity_ObjectFromEdge2, cavity_ObjectFromEdge3 = object_from(cavity.edge(at (1.58579, 1.41421, 5.5), at (1.58579, -1.41421, 5.5)))
  r_pad_ObjectFromEdge1..r_pad_ObjectFromEdge4 = object_from(r_pad.edge(all 4))
  cavity_ObjectFromEdge2.unite(cavity_ObjectFromEdge3)
  cavity_ObjectFromEdge2.subtract(r_pad_ObjectFromEdge1..r_pad_ObjectFromEdge4)
boundaries and excitations:
  pad_pec: Perfect E Objects=[l_pad, r_pad]
  taper_pec: Perfect E Objects=[l_pad_taper, r_pad_taper]
  LumpRLC1: Lumped RLC Objects=jj CurrentLine{(0.025, 0, 5.5) -> (-0.025, 0, 5.5)} RLC_Type=Parallel Inductance=LJ
  vac_imp: Impedance Faces=cavity.face(+z end) Resistance=377 Reactance=0
  Imped1: Impedance Faces=cavity.face(at (0, 6.5, 0), at (0, 0, 0), at (0, -6.5, 0)) Resistance=377 Reactance=0
mesh:
  chip_surface_mesh: LengthBased Faces=chip.face(+z) MaxLength=4*w_pad
  post_wall_mesh: LengthBased Faces=cavity.face(at (-5, 0, 9), at (1, 0, 9)) MaxLength=4*w_pad
  jj_mesh: LengthBased Objects=jj MaxLength=0.01mm
  taper_mesh: LengthBased Objects=[l_pad_taper, r_pad_taper] MaxLength=0.01mm
  pad_mesh: LengthBased Objects=[r_pad, l_pad] MaxLength=w_pad
  top_post_mesh: LengthBased Faces=cavity.face(at (3, 0, 12.5), at (-3, 0, 12.5)) MaxLength=0.8mm
  cavity_walls_mesh: LengthBased Faces=cavity.face(at (-10, 0, 45), +z end) MaxLength=15.8mm
setups:
  Setup1: HfssEigen MinimumFrequency=1.77515GHz NumModes=8 MaxDeltaFreq=0.05 ConvergeOnRealFreq=true MaximumPasses=30 MinimumPasses=1 MinimumConvergedPasses=1 PercentRefinement=30 BasisOrder=-1
source amplitudes:
  #-10:1, #-10:3..#-10:8: 0 0deg
  #-10:2: 1 0deg
optimetrics:
  LJ_sweep: Parametric Sim._Setups=[Setup1]
    sweep LJ: DEC 0.1nH 100nH 3
  LJ_crossing_refinement: Parametric Sim._Setups=[Setup1]
    sweep LJ: LIN 10nH 25nH 1nH
field calculator expressions:
  UE_surf = Mag_E | 2 | Pow | EnterSurface(cavity_ObjectFromFace1) | SurfaceValue | Integrate | Mag_E | 2 | Pow | EnterSurface(cavity_ObjectFromFace2) | SurfaceValue | Integrate | + | Mag_E | 2 | Pow | EnterSurface(cavity_ObjectFromFace3) | SurfaceValue | Integrate | + | Mag_E | 2 | Pow | EnterSurface(cavity_ObjectFromFace4) | SurfaceValue | Integrate | + | Mag_E | 2 | Pow | EnterSurface(cavity_ObjectFromFace4_ObjectFromFace1) | SurfaceValue | Integrate | + | Mag_E | 2 | Pow | EnterSurface(cavity_ObjectFromFace5) | SurfaceValue | Integrate | + | Mag_E | 2 | Pow | EnterSurface(cavity_ObjectFromFace6) | SurfaceValue | Integrate | + | Scalar_Function(FuncValue='t_ox') | * | Scalar_Function(FuncValue='eps_al2o3') | *
  UE_sub = Mag_E | 2 | Pow | EnterVolume(chip) | VolumeValue | Integrate | 11.5 | *
  UE_vac = Mag_E | 2 | Pow | EnterVolume(cavity) | VolumeValue | Integrate
  UE_tot = UE_sub | UE_vac | +
  pe_surf = UE_surf | UE_tot | /
  pe_sub = UE_sub | UE_tot | /
  UH_tot = Mag_H | 2 | Pow | EnterVolume(AllObjects) | VolumeValue | Integrate
  UH_pads = Mag_H | 2 | Pow | EnterSurface(l_pad) | SurfaceValue | Integrate | Mag_H | 2 | Pow | EnterSurface(r_pad) | SurfaceValue | Integrate | + | Scalar_Function(FuncValue='lambdaL') | *
  pm_pads = UH_pads | UH_tot | /
  UH_cav_walls = Mag_H | 2 | Pow | EnterSurface(cavity) | SurfaceValue | Integrate | Scalar_Function(FuncValue='lambdaL') | *
  pm_cav_walls = UH_cav_walls | UH_tot | /
  J_seams = Mag_Jsurf | 2 | Pow | EnterLine(cavity_ObjectFromEdge1) | LineValue | Integrate | Mag_Jsurf | 2 | Pow | EnterLine(cavity_ObjectFromEdge2) | LineValue | Integrate | +
  yseam = J_seams | UH_tot | /
  w0_mu0 = 7.89568352087149e-06 | Output_Variable(Freq, 4) | Real | *
  yseam_correct = J_seams | UH_tot | w0_mu0 | * | /
field plots:
  Vector_E1: E Field on Setup1 : LastAdaptive at Phase=0deg
  Vector_Jsurf1: Jsurf over jj.face l_pad.face(at (-1.6375, 0, 5.5)) l_pad_taper.face r_pad.face(at (1.6375, 0, 5.5)) r_pad_taper.face cavity.face(at (3, 0, 12.5), at (1, 0, 9), at (-3, 0, 12.5), at (-5, 0, 9)) on Setup1 : LastAdaptive at Phase=90deg
reports:
  Calculator Expressions Plot 1: pe_surf, pe_sub vs LJ on Setup1 : LastAdaptive [Phase=0deg]
  Calculator Expressions Plot 2: pm_pads, pm_cav_walls vs LJ on Setup1 : LastAdaptive [Phase=90deg]
  Eigen Modes Plot 1: re(Mode(1)), re(Mode(2)), re(Mode(3)), re(Mode(4)), re(Mode(5)), re(Mode(6)), re(Mode(7)), re(Mode(8)) vs LJ on Setup1 : LastAdaptive; markers m1 at 10nH, m2 at 1nH, m3 at 100nH
  Eigen Q Plot 1: Q(1), Q(2), Q(3), Q(4), Q(5), Q(6), Q(7), Q(8) vs LJ on Setup1 : LastAdaptive; markers m1 at 10nH, m2 at 1nH
  Calculator Expressions Plot 6: yseam_correct vs LJ on Setup1 : LastAdaptive [Phase=90deg]

design two_post_leaf_spring_jj_shorted (HFSS, Eigenmode, model units mm)
variables:
  t_chip = 450um
  w_chip = 6mm
  l_chip = 28mm
  z_shift = 9.5mm
  chip_zoffset = 5.5mm
  l_taper = 0.25mm
  l_junc = 50um
  w_junc = 50um
  l_pad = w_chip/2 - l_taper - l_junc/2
  w_pad = 0.5mm
  LJ = 21.544347nH
  t_ox = 3nm
  eps_al2o3 = 10
  lambdaL = 60nm
geometry:
  Solid2 = imported_body(Z:\tcav\inventor\two_post_cylindrical_coupler\two_post_cylindrical_coupler_leaf_springs.stp)
  Solid2.rotate(axis=X, angle=90deg)
  Solid2.move(0mm, 0mm, z_shift)
  cavity [vacuum] = cylinder(axis=Z, base_centre=(0mm, 0mm, 0mm), radius=13mm, height=84.5mm)
  cavity.subtract(Solid2)
  chip [sapphire] = box(corner=(-w_chip/2, -l_chip/2, chip_zoffset-t_chip), size=(w_chip, l_chip, t_chip))
  chip_1 = chip.copy()
  cavity.subtract(chip_1)
  l_pad = rectangle(corner=(-w_chip/2, -w_pad/2, chip_zoffset), x_size=l_pad, y_size=w_pad)
  l_pad_taper = rectangle(corner=(-l_junc/2-l_taper, -w_junc/2, chip_zoffset), x_size=l_taper, y_size=w_junc)
  jj = rectangle(corner=(-w_junc/2, -l_junc/2, chip_zoffset), x_size=w_junc, y_size=l_junc)
  r_pad_taper = rectangle(corner=(l_junc/2, -w_junc/2, chip_zoffset), x_size=l_taper, y_size=w_junc)
  r_pad = rectangle(corner=(l_taper+ l_junc/2, -w_pad/2, chip_zoffset), x_size=l_pad, y_size=w_pad)
  cavity_ObjectFromFace1 = object_from(cavity.face(at (7.98514, 0, 5)))
  cavity_ObjectFromFace2 = object_from(cavity.face(at (6.70752, 6.5, 5)))
  cavity_ObjectFromFace3 = object_from(cavity.face(at (6.70752, -6.5, 5)))
  cavity_ObjectFromFace4 = object_from(cavity.face(at (-6.70752, 6.5, 5)))
  cavity_ObjectFromFace5 = object_from(cavity.face(at (-7.98514, 0, 5)))
  cavity_ObjectFromFace6 = object_from(cavity.face(at (-6.70752, -6.5, 5)))
  cavity_ObjectFromFace4_ObjectFromFace1 = object_from(cavity_ObjectFromFace4.face)
  cavity_ObjectFromEdge1 = object_from(cavity.edge(at (-1, 0, 5.5)))
  l_pad_ObjectFromEdge1..l_pad_ObjectFromEdge4 = object_from(l_pad.edge(all 4))
  cavity_ObjectFromEdge1.subtract(l_pad_ObjectFromEdge1..l_pad_ObjectFromEdge4)
  cavity_ObjectFromEdge2, cavity_ObjectFromEdge3 = object_from(cavity.edge(at (1.58579, 1.41421, 5.5), at (1.58579, -1.41421, 5.5)))
  r_pad_ObjectFromEdge1..r_pad_ObjectFromEdge4 = object_from(r_pad.edge(all 4))
  cavity_ObjectFromEdge2.unite(cavity_ObjectFromEdge3)
  cavity_ObjectFromEdge2.subtract(r_pad_ObjectFromEdge1..r_pad_ObjectFromEdge4)
boundaries and excitations:
  pad_pec: Perfect E Objects=[l_pad, r_pad]
  taper_pec: Perfect E Objects=[l_pad_taper, r_pad_taper]
  vac_imp: Impedance Faces=cavity.face(+z end) Resistance=377 Reactance=0
  Imped1: Impedance Faces=cavity.face(at (0, 6.5, 0), at (0, 0, 0), at (0, -6.5, 0)) Resistance=377 Reactance=0
  PerfE1: Perfect E Objects=jj
mesh:
  chip_surface_mesh: LengthBased Faces=chip.face(+z) MaxLength=4*w_pad
  post_wall_mesh: LengthBased Faces=cavity.face(at (-5, 0, 9), at (1, 0, 9)) MaxLength=4*w_pad
  jj_mesh: LengthBased Objects=jj MaxLength=0.01mm
  taper_mesh: LengthBased Objects=[l_pad_taper, r_pad_taper] MaxLength=0.01mm
  pad_mesh: LengthBased Objects=[r_pad, l_pad] MaxLength=w_pad
  top_post_mesh: LengthBased Faces=cavity.face(at (3, 0, 12.5), at (-3, 0, 12.5)) MaxLength=0.8mm
  cavity_walls_mesh: LengthBased Faces=cavity.face(at (-10, 0, 45), +z end) MaxLength=15.8mm
setups:
  Setup1: HfssEigen MinimumFrequency=1.77515GHz NumModes=4 MaxDeltaFreq=0.05 ConvergeOnRealFreq=true MaximumPasses=30 MinimumPasses=1 MinimumConvergedPasses=1 PercentRefinement=30 BasisOrder=-1
source amplitudes:
  #-10:1, #-10:3, #-10:4: 0 0deg
  #-10:2: 1 0deg
optimetrics:
  LJ_sweep: Parametric Sim._Setups=[Setup1]
    sweep LJ: DEC 0.1nH 100nH 3
  LJ_crossing_refinement: Parametric Sim._Setups=[Setup1]
    sweep LJ: LIN 10nH 25nH 1nH
field calculator expressions:
  UE_surf = Mag_E | 2 | Pow | EnterSurface(cavity_ObjectFromFace1) | SurfaceValue | Integrate | Mag_E | 2 | Pow | EnterSurface(cavity_ObjectFromFace2) | SurfaceValue | Integrate | + | Mag_E | 2 | Pow | EnterSurface(cavity_ObjectFromFace3) | SurfaceValue | Integrate | + | Mag_E | 2 | Pow | EnterSurface(cavity_ObjectFromFace4) | SurfaceValue | Integrate | + | Mag_E | 2 | Pow | EnterSurface(cavity_ObjectFromFace4_ObjectFromFace1) | SurfaceValue | Integrate | + | Mag_E | 2 | Pow | EnterSurface(cavity_ObjectFromFace5) | SurfaceValue | Integrate | + | Mag_E | 2 | Pow | EnterSurface(cavity_ObjectFromFace6) | SurfaceValue | Integrate | + | Scalar_Function(FuncValue='t_ox') | * | Scalar_Function(FuncValue='eps_al2o3') | *
  UE_sub = Mag_E | 2 | Pow | EnterVolume(chip) | VolumeValue | Integrate | 11.5 | *
  UE_vac = Mag_E | 2 | Pow | EnterVolume(cavity) | VolumeValue | Integrate
  UE_tot = UE_sub | UE_vac | +
  pe_surf = UE_surf | UE_tot | /
  pe_sub = UE_sub | UE_tot | /
  UH_tot = Mag_H | 2 | Pow | EnterVolume(AllObjects) | VolumeValue | Integrate
  UH_pads = Mag_H | 2 | Pow | EnterSurface(l_pad) | SurfaceValue | Integrate | Mag_H | 2 | Pow | EnterSurface(r_pad) | SurfaceValue | Integrate | + | Scalar_Function(FuncValue='lambdaL') | *
  pm_pads = UH_pads | UH_tot | /
  UH_cav_walls = Mag_H | 2 | Pow | EnterSurface(cavity) | SurfaceValue | Integrate | Scalar_Function(FuncValue='lambdaL') | *
  pm_cav_walls = UH_cav_walls | UH_tot | /
  J_seams = Mag_Jsurf | 2 | Pow | EnterLine(cavity_ObjectFromEdge1) | LineValue | Integrate | Mag_Jsurf | 2 | Pow | EnterLine(cavity_ObjectFromEdge2) | LineValue | Integrate | +
  yseam = J_seams | UH_tot | /
field plots:
  Vector_E1: E Field on Setup1 : LastAdaptive at Phase=0deg
  Vector_Jsurf1: Jsurf over jj.face l_pad.face(at (-1.6375, 0, 5.5)) l_pad_taper.face r_pad.face(at (1.6375, 0, 5.5)) r_pad_taper.face cavity.face(at (3, 0, 12.5), at (1, 0, 9), at (-3, 0, 12.5), at (-5, 0, 9)) on Setup1 : LastAdaptive at Phase=90deg
reports:
  Eigen Modes Plot 1: re(Mode(1)), re(Mode(2)), re(Mode(3)), re(Mode(4)) vs LJ on Setup1 : LastAdaptive; markers m1 at 10nH, m2 at 1nH, m3 at 21.544347nH, m4 at 21.544347nH, m5 at 15nH, m6 at 15nH, m7 at 16nH, m8 at 16nH
  Eigen Q Plot 1: Q(1), Q(2), Q(3), Q(4) vs LJ on Setup1 : LastAdaptive
  Calculator Expressions Plot 1: pe_surf, pe_sub vs LJ on Setup1 : LastAdaptive [Phase=0deg]
  Calculator Expressions Plot 2: pm_pads, pm_cav_walls vs LJ on Setup1 : LastAdaptive [Phase=90deg]
  Calculator Expressions Plot 5: yseam vs LJ on Setup1 : LastAdaptive [Phase=90deg]

design two_post_leaf_spring_jj_open (HFSS, Eigenmode, model units mm)
variables:
  t_chip = 450um
  w_chip = 6mm
  l_chip = 28mm
  z_shift = 9.5mm
  chip_zoffset = 5.5mm
  l_taper = 0.25mm
  l_junc = 50um
  w_junc = 50um
  l_pad = w_chip/2 - l_taper - l_junc/2
  w_pad = 0.5mm
  LJ = 21.544347nH
  t_ox = 3nm
  eps_al2o3 = 10
  lambdaL = 60nm
geometry:
  Solid2 = imported_body(Z:\tcav\inventor\two_post_cylindrical_coupler\two_post_cylindrical_coupler_leaf_springs.stp)
  Solid2.rotate(axis=X, angle=90deg)
  Solid2.move(0mm, 0mm, z_shift)
  cavity [vacuum] = cylinder(axis=Z, base_centre=(0mm, 0mm, 0mm), radius=13mm, height=84.5mm)
  cavity.subtract(Solid2)
  chip [sapphire] = box(corner=(-w_chip/2, -l_chip/2, chip_zoffset-t_chip), size=(w_chip, l_chip, t_chip))
  chip_1 = chip.copy()
  cavity.subtract(chip_1)
  l_pad = rectangle(corner=(-w_chip/2, -w_pad/2, chip_zoffset), x_size=l_pad, y_size=w_pad)
  l_pad_taper = rectangle(corner=(-l_junc/2-l_taper, -w_junc/2, chip_zoffset), x_size=l_taper, y_size=w_junc)
  r_pad_taper = rectangle(corner=(l_junc/2, -w_junc/2, chip_zoffset), x_size=l_taper, y_size=w_junc)
  r_pad = rectangle(corner=(l_taper+ l_junc/2, -w_pad/2, chip_zoffset), x_size=l_pad, y_size=w_pad)
  cavity_ObjectFromFace1 = object_from(cavity.face(at (7.98514, 0, 5)))
  cavity_ObjectFromFace2 = object_from(cavity.face(at (6.70752, 6.5, 5)))
  cavity_ObjectFromFace3 = object_from(cavity.face(at (6.70752, -6.5, 5)))
  cavity_ObjectFromFace4 = object_from(cavity.face(at (-6.70752, 6.5, 5)))
  cavity_ObjectFromFace5 = object_from(cavity.face(at (-7.98514, 0, 5)))
  cavity_ObjectFromFace6 = object_from(cavity.face(at (-6.70752, -6.5, 5)))
  cavity_ObjectFromFace4_ObjectFromFace1 = object_from(cavity_ObjectFromFace4.face)
  cavity_ObjectFromEdge1 = object_from(cavity.edge(at (-1, 0, 5.5)))
  l_pad_ObjectFromEdge1..l_pad_ObjectFromEdge4 = object_from(l_pad.edge(all 4))
  cavity_ObjectFromEdge1.subtract(l_pad_ObjectFromEdge1..l_pad_ObjectFromEdge4)
  cavity_ObjectFromEdge2, cavity_ObjectFromEdge3 = object_from(cavity.edge(at (1.58579, 1.41421, 5.5), at (1.58579, -1.41421, 5.5)))
  r_pad_ObjectFromEdge1..r_pad_ObjectFromEdge4 = object_from(r_pad.edge(all 4))
  cavity_ObjectFromEdge2.unite(cavity_ObjectFromEdge3)
  cavity_ObjectFromEdge2.subtract(r_pad_ObjectFromEdge1..r_pad_ObjectFromEdge4)
boundaries and excitations:
  pad_pec: Perfect E Objects=[l_pad, r_pad]
  taper_pec: Perfect E Objects=[l_pad_taper, r_pad_taper]
  vac_imp: Impedance Faces=cavity.face(+z end) Resistance=377 Reactance=0
  Imped1: Impedance Faces=cavity.face(at (0, 6.5, 0), at (0, 0, 0), at (0, -6.5, 0)) Resistance=377 Reactance=0
mesh:
  chip_surface_mesh: LengthBased Faces=chip.face(+z) MaxLength=4*w_pad
  post_wall_mesh: LengthBased Faces=cavity.face(at (-5, 0, 9), at (1, 0, 9)) MaxLength=4*w_pad
  taper_mesh: LengthBased Objects=[l_pad_taper, r_pad_taper] MaxLength=0.01mm
  pad_mesh: LengthBased Objects=[r_pad, l_pad] MaxLength=w_pad
  top_post_mesh: LengthBased Faces=cavity.face(at (3, 0, 12.5), at (-3, 0, 12.5)) MaxLength=0.8mm
  cavity_walls_mesh: LengthBased Faces=cavity.face(at (-10, 0, 45), +z end) MaxLength=15.8mm
setups:
  Setup1: HfssEigen MinimumFrequency=1.77515GHz NumModes=4 MaxDeltaFreq=0.05 ConvergeOnRealFreq=true MaximumPasses=30 MinimumPasses=1 MinimumConvergedPasses=1 PercentRefinement=30 BasisOrder=-1
source amplitudes:
  #-10:1, #-10:3, #-10:4: 0 0deg
  #-10:2: 1 0deg
optimetrics:
  LJ_sweep: Parametric Sim._Setups=[Setup1]
    sweep LJ: DEC 0.1nH 100nH 3
  LJ_crossing_refinement: Parametric Sim._Setups=[Setup1]
    sweep LJ: LIN 10nH 25nH 1nH
field calculator expressions:
  UE_surf = Mag_E | 2 | Pow | EnterSurface(cavity_ObjectFromFace1) | SurfaceValue | Integrate | Mag_E | 2 | Pow | EnterSurface(cavity_ObjectFromFace2) | SurfaceValue | Integrate | + | Mag_E | 2 | Pow | EnterSurface(cavity_ObjectFromFace3) | SurfaceValue | Integrate | + | Mag_E | 2 | Pow | EnterSurface(cavity_ObjectFromFace4) | SurfaceValue | Integrate | + | Mag_E | 2 | Pow | EnterSurface(cavity_ObjectFromFace4_ObjectFromFace1) | SurfaceValue | Integrate | + | Mag_E | 2 | Pow | EnterSurface(cavity_ObjectFromFace5) | SurfaceValue | Integrate | + | Mag_E | 2 | Pow | EnterSurface(cavity_ObjectFromFace6) | SurfaceValue | Integrate | + | Scalar_Function(FuncValue='t_ox') | * | Scalar_Function(FuncValue='eps_al2o3') | *
  UE_sub = Mag_E | 2 | Pow | EnterVolume(chip) | VolumeValue | Integrate | 11.5 | *
  UE_vac = Mag_E | 2 | Pow | EnterVolume(cavity) | VolumeValue | Integrate
  UE_tot = UE_sub | UE_vac | +
  pe_surf = UE_surf | UE_tot | /
  pe_sub = UE_sub | UE_tot | /
  UH_tot = Mag_H | 2 | Pow | EnterVolume(AllObjects) | VolumeValue | Integrate
  UH_pads = Mag_H | 2 | Pow | EnterSurface(l_pad) | SurfaceValue | Integrate | Mag_H | 2 | Pow | EnterSurface(r_pad) | SurfaceValue | Integrate | + | Scalar_Function(FuncValue='lambdaL') | *
  pm_pads = UH_pads | UH_tot | /
  UH_cav_walls = Mag_H | 2 | Pow | EnterSurface(cavity) | SurfaceValue | Integrate | Scalar_Function(FuncValue='lambdaL') | *
  pm_cav_walls = UH_cav_walls | UH_tot | /
  J_seams = Mag_Jsurf | 2 | Pow | EnterLine(cavity_ObjectFromEdge1) | LineValue | Integrate | Mag_Jsurf | 2 | Pow | EnterLine(cavity_ObjectFromEdge2) | LineValue | Integrate | +
  yseam = J_seams | UH_tot | /
field plots:
  Vector_E1: E Field on Setup1 : LastAdaptive at Phase=0deg
  Vector_Jsurf1: Jsurf over l_pad.face(at (-1.6375, 0, 5.5)) l_pad_taper.face r_pad.face(at (1.6375, 0, 5.5)) r_pad_taper.face cavity.face(at (3, 0, 12.5), at (1, 0, 9), at (-3, 0, 12.5), at (-5, 0, 9)) on Setup1 : LastAdaptive at Phase=90deg
reports:
  Eigen Modes Plot 1: re(Mode(1)), re(Mode(2)), re(Mode(3)), re(Mode(4)) vs LJ on Setup1 : LastAdaptive; markers m1 at 10nH, m2 at 1nH, m3 at 21.544347nH, m4 at 21.544347nH, m5 at 15nH, m6 at 15nH, m7 at 16nH, m8 at 16nH
  Eigen Q Plot 1: Q(1), Q(2), Q(3), Q(4) vs LJ on Setup1 : LastAdaptive
  Calculator Expressions Plot 1: pe_surf, pe_sub vs LJ on Setup1 : LastAdaptive [Phase=0deg]
  Calculator Expressions Plot 2: pm_pads, pm_cav_walls vs LJ on Setup1 : LastAdaptive [Phase=90deg]
  Calculator Expressions Plot 5: yseam vs LJ on Setup1 : LastAdaptive [Phase=90deg]

design two_post_leaf_spring_jj_bbq (HFSS, HFSS Modal Network, model units mm)
variables:
  t_chip = 450um
  w_chip = 6mm
  l_chip = 28mm
  z_shift = 9.5mm
  chip_zoffset = 5.5mm
  l_taper = 0.25mm
  l_junc = 50um
  w_junc = 50um
  l_pad = w_chip/2 - l_taper - l_junc/2
  w_pad = 0.5mm
  LJ = 1nH
  t_ox = 3nm
  eps_al2o3 = 10
  lambdaL = 60nm
geometry:
  Solid2 = imported_body(Z:\tcav\inventor\two_post_cylindrical_coupler\two_post_cylindrical_coupler_leaf_springs.stp)
  Solid2.rotate(axis=X, angle=90deg)
  Solid2.move(0mm, 0mm, z_shift)
  cavity [vacuum] = cylinder(axis=Z, base_centre=(0mm, 0mm, 0mm), radius=13mm, height=84.5mm)
  cavity.subtract(Solid2)
  chip [sapphire] = box(corner=(-w_chip/2, -l_chip/2, chip_zoffset-t_chip), size=(w_chip, l_chip, t_chip))
  chip_1 = chip.copy()
  cavity.subtract(chip_1)
  l_pad = rectangle(corner=(-w_chip/2, -w_pad/2, chip_zoffset), x_size=l_pad, y_size=w_pad)
  l_pad_taper = rectangle(corner=(-l_junc/2-l_taper, -w_junc/2, chip_zoffset), x_size=l_taper, y_size=w_junc)
  jj = rectangle(corner=(-w_junc/2, -l_junc/2, chip_zoffset), x_size=w_junc, y_size=l_junc)
  r_pad_taper = rectangle(corner=(l_junc/2, -w_junc/2, chip_zoffset), x_size=l_taper, y_size=w_junc)
  r_pad = rectangle(corner=(l_taper+ l_junc/2, -w_pad/2, chip_zoffset), x_size=l_pad, y_size=w_pad)
  cavity_ObjectFromFace1 = object_from(cavity.face(at (7.98514, 0, 5)))
  cavity_ObjectFromFace2 = object_from(cavity.face(at (6.70752, 6.5, 5)))
  cavity_ObjectFromFace3 = object_from(cavity.face(at (6.70752, -6.5, 5)))
  cavity_ObjectFromFace4 = object_from(cavity.face(at (-6.70752, 6.5, 5)))
  cavity_ObjectFromFace5 = object_from(cavity.face(at (-7.98514, 0, 5)))
  cavity_ObjectFromFace6 = object_from(cavity.face(at (-6.70752, -6.5, 5)))
  cavity_ObjectFromFace4_ObjectFromFace1 = object_from(cavity_ObjectFromFace4.face)
  cavity_ObjectFromEdge1 = object_from(cavity.edge(at (-1, 0, 5.5)))
  l_pad_ObjectFromEdge1..l_pad_ObjectFromEdge4 = object_from(l_pad.edge(all 4))
  cavity_ObjectFromEdge1.subtract(l_pad_ObjectFromEdge1..l_pad_ObjectFromEdge4)
  cavity_ObjectFromEdge2, cavity_ObjectFromEdge3 = object_from(cavity.edge(at (1.58579, 1.41421, 5.5), at (1.58579, -1.41421, 5.5)))
  r_pad_ObjectFromEdge1..r_pad_ObjectFromEdge4 = object_from(r_pad.edge(all 4))
  cavity_ObjectFromEdge2.unite(cavity_ObjectFromEdge3)
  cavity_ObjectFromEdge2.subtract(r_pad_ObjectFromEdge1..r_pad_ObjectFromEdge4)
boundaries and excitations:
  pad_pec: Perfect E Objects=[l_pad, r_pad]
  taper_pec: Perfect E Objects=[l_pad_taper, r_pad_taper]
  vac_imp: Impedance Faces=cavity.face(+z end) Resistance=377 Reactance=0
  Imped1: Impedance Faces=cavity.face(at (0, 6.5, 0), at (0, 0, 0), at (0, -6.5, 0)) Resistance=377 Reactance=0
  LumpPort: Lumped Port Objects=jj LumpedPortType=Modal Modes{Mode1{IntLine{(0.025, 0, 5.5) -> (-0.025, 0, 5.5)} CharImp=Zpi RenormImp=50ohm}} Impedance=50ohm
mesh:
  chip_surface_mesh: LengthBased Faces=chip.face(+z) MaxLength=4*w_pad
  post_wall_mesh: LengthBased Faces=cavity.face(at (-5, 0, 9), at (1, 0, 9)) MaxLength=4*w_pad
  jj_mesh: LengthBased Objects=jj MaxLength=0.01mm
  taper_mesh: LengthBased Objects=[l_pad_taper, r_pad_taper] MaxLength=0.01mm
  pad_mesh: LengthBased Objects=[r_pad, l_pad] MaxLength=w_pad
  top_post_mesh: LengthBased Faces=cavity.face(at (3, 0, 12.5), at (-3, 0, 12.5)) MaxLength=0.8mm
  cavity_walls_mesh: LengthBased Faces=cavity.face(at (-10, 0, 45), +z end) MaxLength=15.8mm
setups:
  Setup: HfssDriven Frequency=1GHz MaxDeltaS=0.1 MaximumPasses=10 MinimumPasses=1 MinimumConvergedPasses=1 PercentRefinement=30 BasisOrder=-1 PortAccuracy=2 DrivenSolverType="Direct Solver"
    sweep Interpolating_0: 2GHz to 15GHz, 20001 points; Type=Interpolating InterpTolerance=0.5 InterpMaxSolns=250 InterpUsePortImped=false PassivityErrorTolerance=0.0001
    sweep Discrete_Sweep_0: 2GHz to 5.9741GHz, 201 points; Type=Discrete SaveFields
    sweep Discrete_Sweep_1: 5.98093GHz to 7.3469GHz, 201 points; Type=Discrete SaveFields
    sweep Discrete_Sweep_2: 7.35373GHz to 12.5976GHz, 201 points; Type=Discrete SaveFields
    sweep Discrete_Sweep_3: 12.60443GHz to 13.9704GHz, 201 points; Type=Discrete SaveFields
    sweep Discrete_Sweep_4: 13.97723GHz to 15GHz, 201 points; Type=Discrete SaveFields
source amplitudes:
  LumpPort:1: 1W 0deg
field calculator expressions:
  UE_surf = Mag_E | 2 | Pow | EnterSurface(cavity_ObjectFromFace1) | SurfaceValue | Integrate | Mag_E | 2 | Pow | EnterSurface(cavity_ObjectFromFace2) | SurfaceValue | Integrate | + | Mag_E | 2 | Pow | EnterSurface(cavity_ObjectFromFace3) | SurfaceValue | Integrate | + | Mag_E | 2 | Pow | EnterSurface(cavity_ObjectFromFace4) | SurfaceValue | Integrate | + | Mag_E | 2 | Pow | EnterSurface(cavity_ObjectFromFace4_ObjectFromFace1) | SurfaceValue | Integrate | + | Mag_E | 2 | Pow | EnterSurface(cavity_ObjectFromFace5) | SurfaceValue | Integrate | + | Mag_E | 2 | Pow | EnterSurface(cavity_ObjectFromFace6) | SurfaceValue | Integrate | + | Scalar_Function(FuncValue='t_ox') | * | Scalar_Function(FuncValue='eps_al2o3') | *
  UE_sub = Mag_E | 2 | Pow | EnterVolume(chip) | VolumeValue | Integrate | 11.5 | *
  UE_vac = Mag_E | 2 | Pow | EnterVolume(cavity) | VolumeValue | Integrate
  UE_tot = UE_sub | UE_vac | +
  pe_surf = UE_surf | UE_tot | /
  pe_sub = UE_sub | UE_tot | /
  UH_tot = Mag_H | 2 | Pow | EnterVolume(AllObjects) | VolumeValue | Integrate
  UH_pads = Mag_H | 2 | Pow | EnterSurface(l_pad) | SurfaceValue | Integrate | Mag_H | 2 | Pow | EnterSurface(r_pad) | SurfaceValue | Integrate | + | Scalar_Function(FuncValue='lambdaL') | *
  pm_pads = UH_pads | UH_tot | /
  UH_cav_walls = Mag_H | 2 | Pow | EnterSurface(cavity) | SurfaceValue | Integrate | Scalar_Function(FuncValue='lambdaL') | *
  pm_cav_walls = UH_cav_walls | UH_tot | /
  J_seams = Mag_Jsurf | 2 | Pow | EnterLine(cavity_ObjectFromEdge1) | LineValue | Integrate | Mag_Jsurf | 2 | Pow | EnterLine(cavity_ObjectFromEdge2) | LineValue | Integrate | +
  yseam = J_seams | UH_tot | /
  w0_mu0 = 7.89568352087149e-06 | Output_Variable(Freq, 4) | Real | *
  yseam_correct = J_seams | UH_tot | w0_mu0 | * | /
field plots:
  Vector_E1: E Field on Setup : LastAdaptive at Freq=1GHz Phase=0deg
reports:
  Interpolating_0: im(Y(LumpPort,LumpPort)) vs Freq on Setup : Interpolating_0
  Discrete_Sweep_0: re(Y(1,1)) vs Freq on Setup : Discrete_Sweep_0
  Discrete_Sweep_01: im(Y(1,1)) vs Freq on Setup : Discrete_Sweep_0
  Discrete_Sweep_1: re(Y(1,1)) vs Freq on Setup : Discrete_Sweep_1
  Discrete_Sweep_11: im(Y(1,1)) vs Freq on Setup : Discrete_Sweep_1
  Discrete_Sweep_2: re(Y(1,1)) vs Freq on Setup : Discrete_Sweep_2
  Discrete_Sweep_21: im(Y(1,1)) vs Freq on Setup : Discrete_Sweep_2
  Discrete_Sweep_3: re(Y(1,1)) vs Freq on Setup : Discrete_Sweep_3
  Discrete_Sweep_31: im(Y(1,1)) vs Freq on Setup : Discrete_Sweep_3
  Discrete_Sweep_4: re(Y(1,1)) vs Freq on Setup : Discrete_Sweep_4
  Discrete_Sweep_41: im(Y(1,1)) vs Freq on Setup : Discrete_Sweep_4
