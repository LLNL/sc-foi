# Ansys Electronics Desktop project, version 2022.1
materials:
  vacuum: permittivity=1
  sapphire: permittivity=10 dielectric_loss_tangent=1.9e-08

design two_post_leaf_spring_degen_cavities_ab_jj (HFSS, Eigenmode, model units mm)
variables:
  t_chip = 450um
  w_chip = 6mm
  l_chip = 28mm
  z_shift = 9.5mm
  chip_zoffset = 5.5mm
  l_taper = 0.25mm
  l_junc = 50um
  w_junc = 50um
  l_pad = w_chip/2 - l_taper - l_junc/2
  w_pad = 0.5mm
  LJ = 1nH
  t_ox = 3nm
  eps_al2o3 = 10
  lambdaL = 60nm
  d_cpl_cav = 20mm
  l_cpl_tunnel = 3mm
  d_cpl_tunnel = 6mm
  d_cav_a = 8mm
  d_cav_b = 8mm
  d_post_a = 3mm
  d_post_b = 3mm
  h_post_a = 14mm
  h_post_b = 14mm
  h_cav_a = 140mm
  h_cav_b = 140mm
  leaf_spring_z_offset = 5mm
  dl_tunnel_cpl = 5mm
  tunnel_z_offset = 2mm
  h_post_cpl = 7mm
geometry:
  Solid2 = imported_body(Z:\tcav\inventor\two_post_cylindrical_coupler\two_post_cylindrical_coupler_leaf_springs.stp)
  Solid2.rotate(axis=X, angle=90deg)
  Solid2.move(0mm, 0mm, z_shift)
  coupler_cavity [vacuum] = cylinder(axis=Z, base_centre=(0mm, 0mm, 0mm), radius=13mm, height=84.5mm)
  coupler_cavity.subtract(Solid2)
  chip [sapphire] = box(corner=(-w_chip/2, -l_chip/2, chip_zoffset-t_chip), size=(w_chip, l_chip, t_chip))
  chip_1 = chip.copy()
  coupler_cavity.subtract(chip_1)
  l_pad = rectangle(corner=(-w_chip/2, -w_pad/2, chip_zoffset), x_size=l_pad, y_size=w_pad)
  l_pad_taper = rectangle(corner=(-l_junc/2-l_taper, -w_junc/2, chip_zoffset), x_size=l_taper, y_size=w_junc)
  jj = rectangle(corner=(-w_junc/2, -l_junc/2, chip_zoffset), x_size=w_junc, y_size=l_junc)
  r_pad_taper = rectangle(corner=(l_junc/2, -w_junc/2, chip_zoffset), x_size=l_taper, y_size=w_junc)
  r_pad = rectangle(corner=(l_taper+ l_junc/2, -w_pad/2, chip_zoffset), x_size=l_pad, y_size=w_pad)
  cavity_ObjectFromFace1 = object_from(coupler_cavity.face(at (7.95616, 0, 5)))
  cavity_ObjectFromFace2 = object_from(coupler_cavity.face(at (6.68616, 6.5, 5)))
  cavity_ObjectFromFace3 = object_from(coupler_cavity.face(at (6.68616, -6.5, 5)))
  cavity_ObjectFromFace4 = object_from(coupler_cavity.face(at (-6.68616, 6.5, 5)))
  cavity_ObjectFromFace5 = object_from(coupler_cavity.face(at (-7.95616, 0, 5)))
  cavity_ObjectFromFace6 = object_from(coupler_cavity.face(at (-6.68616, -6.5, 5)))
  cavity_ObjectFromFace4_ObjectFromFace1 = object_from(cavity_ObjectFromFace4.face)
  cavity_ObjectFromEdge1 = object_from(coupler_cavity.edge(at (-1, 0, 5.5)))
  l_pad_ObjectFromEdge1..l_pad_ObjectFromEdge4 = object_from(l_pad.edge(all 4))
  cavity_ObjectFromEdge1.subtract(l_pad_ObjectFromEdge1..l_pad_ObjectFromEdge4)
  cavity_ObjectFromEdge2, cavity_ObjectFromEdge3 = object_from(coupler_cavity.edge(at (1.58579, 1.41421, 5.5), at (1.58579, -1.41421, 5.5)))
  r_pad_ObjectFromEdge1..r_pad_ObjectFromEdge4 = object_from(r_pad.edge(all 4))
  cavity_ObjectFromEdge2.unite(cavity_ObjectFromEdge3)
  cavity_ObjectFromEdge2.subtract(r_pad_ObjectFromEdge1..r_pad_ObjectFromEdge4)
  cavity_a = cylinder(axis=Z, base_centre=(-d_cpl_cav/2-d_cav_a/2-l_cpl_tunnel, 0mm, -(h_post_a-(h_post_cpl + leaf_spring_z_offset))), radius=d_cav_a/2, height=h_cav_a)
  cavity_b = cylinder(axis=Z, base_centre=(d_cpl_cav/2+d_cav_b/2+l_cpl_tunnel, 0mm, -(h_post_b-(h_post_cpl + leaf_spring_z_offset))), radius=d_cav_b/2, height=h_cav_b)
  cavity_a_post = cylinder(axis=Z, base_centre=(-d_cpl_cav/2-d_cav_a/2-l_cpl_tunnel, 0mm, -(h_post_a-(h_post_cpl + leaf_spring_z_offset))), radius=d_post_a/2, height=h_post_a)
  cavity_b_post = cylinder(axis=Z, base_centre=(d_cpl_cav/2+d_cav_b/2+l_cpl_tunnel, 0mm, -(h_post_b-(h_post_cpl + leaf_spring_z_offset))), radius=d_post_b/2, height=h_post_b)
  cavity_b.subtract(cavity_b_post)
  cavity_a.subtract(cavity_a_post)
  tunnel_cpl_a = cylinder(axis=X, base_centre=(-d_cpl_cav/2-l_cpl_tunnel-dl_tunnel_cpl/2, 0mm, max(h_post_a,h_post_b)+tunnel_z_offset), radius=d_cpl_tunnel/2, height=l_cpl_tunnel + dl_tunnel_cpl)
  tunnel_cpl_b = cylinder(axis=X, base_centre=(d_cpl_cav/2-dl_tunnel_cpl/2, 0mm, max(h_post_a,h_post_b)+tunnel_z_offset), radius=d_cpl_tunnel/2, height=l_cpl_tunnel + dl_tunnel_cpl)
  coupler_cavity.unite(cavity_b, cavity_a, tunnel_cpl_a, tunnel_cpl_b)
boundaries and excitations:
  pad_pec: Perfect E Objects=[l_pad, r_pad]
  taper_pec: Perfect E Objects=[l_pad_taper, r_pad_taper]
  LumpRLC1: Lumped RLC Objects=jj CurrentLine{(0.025, 0, 5.5) -> (-0.025, 0, 5.5)} RLC_Type=Parallel Inductance=LJ
  vac_imp: Impedance Faces=coupler_cavity.face(3 of 3) Resistance=377 Reactance=0
  Imped1: Impedance Faces=coupler_cavity.face(at (0, 6.5, 0), at (0, 0, 0), at (0, -6.5, 0)) Resistance=377 Reactance=0
  top_cav_vac: Impedance Faces=coupler_cavity.face(3 of 3, 3 of 3) Resistance=377 Reactance=0
mesh:
  chip_surface_mesh: LengthBased Faces=chip.face(+z) MaxLength=4*w_pad
  post_wall_mesh: LengthBased Faces=coupler_cavity.face(at (-1, 0, 9), at (5, 0, 9)) MaxLength=4*w_pad
  jj_mesh: LengthBased Objects=jj MaxLength=0.01mm
  taper_mesh: LengthBased Objects=[l_pad_taper, r_pad_taper] MaxLength=0.01mm
  pad_mesh: LengthBased Objects=[r_pad, l_pad] MaxLength=w_pad
  top_post_mesh: LengthBased Faces=coupler_cavity.face(at (3, 0, 12.5), at (-3, 0, 12.5)) MaxLength=0.8mm
  cavity_walls_mesh: LengthBased Faces=coupler_cavity.face(at (10, 0, 45), 3 of 3) MaxLength=15.8mm
setups:
  Setup1: HfssEigen MinimumFrequency=1.77515GHz NumModes=6 MaxDeltaFreq=0.005 ConvergeOnRealFreq=true MaximumPasses=30 MinimumPasses=1 MinimumConvergedPasses=1 PercentRefinement=30 BasisOrder=-1
source amplitudes:
  #-10:1: 1 0deg
  #-10:2..#-10:6: 0 0deg
optimetrics:
  LJ_sweep: Parametric Sim._Setups=[Setup1]
    sweep LJ: DEC 0.1nH 100nH 3
  LJ_crossing_refinement: Parametric Sim._Setups=[Setup1]
    sweep LJ: LIN 10nH 25nH 1nH
  dcpl_tunnel_sweep: Parametric Sim._Setups=[Setup1]
    sweep d_cpl_tunnel: LIN 2mm 10mm 2mm
  tunnel_z_offset_sweep: Parametric Sim._Setups=[Setup1]
    sweep tunnel_z_offset: LIN -6mm 4mm 2mm
  tunnel_length_sweep: Parametric Sim._Setups=[Setup1]
    sweep l_cpl_tunnel: LIN 2.25mm 3.75mm 0.25mm
field calculator expressions:
  UE_surf = Mag_E | 2 | Pow | EnterSurface(cavity_ObjectFromFace1) | SurfaceValue | Integrate | Mag_E | 2 | Pow | EnterSurface(cavity_ObjectFromFace2) | SurfaceValue | Integrate | + | Mag_E | 2 | Pow | EnterSurface(cavity_ObjectFromFace3) | SurfaceValue | Integrate | + | Mag_E | 2 | Pow | EnterSurface(cavity_ObjectFromFace4) | SurfaceValue | Integrate | + | Mag_E | 2 | Pow | EnterSurface(cavity_ObjectFromFace4_ObjectFromFace1) | SurfaceValue | Integrate | + | Mag_E | 2 | Pow | EnterSurface(cavity_ObjectFromFace5) | SurfaceValue | Integrate | + | Mag_E | 2 | Pow | EnterSurface(cavity_ObjectFromFace6) | SurfaceValue | Integrate | + | Scalar_Function(FuncValue='t_ox') | * | Scalar_Function(FuncValue='eps_al2o3') | *
  UE_sub = Mag_E | 2 | Pow | EnterVolume(chip) | VolumeValue | Integrate | 11.5 | *
  UH_tot = Mag_H | 2 | Pow | EnterVolume(AllObjects) | VolumeValue | Integrate
  UH_pads = Mag_H | 2 | Pow | EnterSurface(l_pad) | SurfaceValue | Integrate | Mag_H | 2 | Pow | EnterSurface(r_pad) | SurfaceValue | Integrate | + | Scalar_Function(FuncValue='lambdaL') | *
  pm_pads = UH_pads | UH_tot | /
  J_seams = Mag_Jsurf | 2 | Pow | EnterLine(cavity_ObjectFromEdge1) | LineValue | Integrate | Mag_Jsurf | 2 | Pow | EnterLine(cavity_ObjectFromEdge2) | LineValue | Integrate | +
  yseam = J_seams | UH_tot | /
  w0_mu0 = 7.89568352087149e-06 | Output_Variable(Freq, 4) | Real | *
  yseam_correct = J_seams | UH_tot | w0_mu0 | * | /
field plots:
  Vector_E1: E Field on Setup1 : LastAdaptive at Phase=0deg
reports:
  Calculator Expressions Plot 1: pe_surf, pe_sub vs LJ on Setup1 : LastAdaptive [Phase=0deg]
  Calculator Expressions Plot 2: pm_pads, pm_cav_walls vs LJ on Setup1 : LastAdaptive [Phase=90deg]
  Calculator Expressions Plot 6: yseam_correct vs LJ on Setup1 : LastAdaptive [Phase=90deg]
  Eigen Modes Plot 7: re(Mode(1)), re(Mode(2)), re(Mode(3)), re(Mode(4)), re(Mode(5)), re(Mode(6)) vs tunnel_z_offset on Setup1 : LastAdaptive [LJ=1nH l_cpl_tunnel=3mm d_cpl_tunnel=5mm]
  Eigen Q Plot 1: Q(1), Q(2), Q(3), Q(4), Q(5), Q(6) vs tunnel_z_offset on Setup1 : LastAdaptive [LJ=1nH l_cpl_tunnel=3mm d_cpl_tunnel=5mm]
  Mode splitting vs. tunnel z offset: re(Mode(2))-re(Mode(1)) vs tunnel_z_offset on Setup1 : LastAdaptive [LJ=1nH l_cpl_tunnel=3mm d_cpl_tunnel=5mm]
  Eigen Modes Plot 8: re(Mode(1)), re(Mode(2)), re(Mode(3)), re(Mode(4)), re(Mode(5)), re(Mode(6)) vs d_cpl_tunnel on Setup1 : LastAdaptive [LJ=1nH l_cpl_tunnel=3mm tunnel_z_offset=2mm]
  Mode splitting vs. tunnel diameter: re(Mode(2))-re(Mode(1)) vs d_cpl_tunnel on Setup1 : LastAdaptive [LJ=1nH l_cpl_tunnel=3mm tunnel_z_offset=2mm]
  Eigen Q Plot 2: Q(1), Q(2), Q(3), Q(4), Q(5), Q(6) vs d_cpl_tunnel on Setup1 : LastAdaptive [LJ=1nH l_cpl_tunnel=3mm tunnel_z_offset=2mm]
  Eigen Modes Plot 9: re(Mode(1)), re(Mode(2)), re(Mode(3)), re(Mode(4)), re(Mode(5)), re(Mode(6)) vs LJ on Setup1 : LastAdaptive [l_cpl_tunnel=3mm d_cpl_tunnel=6mm tunnel_z_offset=2mm]
   Plot 1: re(Mode(2))-re(Mode(1)) vs LJ on Setup1 : LastAdaptive [l_cpl_tunnel=3mm d_cpl_tunnel=6mm tunnel_z_offset=2mm]; markers m1 at 4.6415888nH, m2 at 1nH
  Solution Convergence Plot 1: MaxDeltaFreq vs Pass on Setup1 : AdaptivePass [LJ=all l_cpl_tunnel=all d_cpl_tunnel=all tunnel_z_offset=all]

design two_post_leaf_spring_degen_cavities_ab_jj_fig_only (HFSS, Eigenmode, model units mm)
variables:
  t_chip = 450um
  w_chip = 6mm
  l_chip = 28mm
  z_shift = 9.5mm
  chip_zoffset = 5.5mm
  l_taper = 0.25mm
  l_junc = 50um
  w_junc = 50um
  l_pad = w_chip/2 - l_taper - l_junc/2
  w_pad = 0.5mm
  LJ = 1nH
  t_ox = 3nm
  eps_al2o3 = 10
  lambdaL = 60nm
  d_cpl_cav = 20mm
  l_cpl_tunnel = 3mm
  d_cpl_tunnel = 6mm
  d_cav_a = 8mm
  d_cav_b = 8mm
  d_post_a = 3mm
  d_post_b = 3mm
  h_post_a = 14mm
  h_post_b = 14mm
  h_cav_a = 140mm
  h_cav_b = 140mm
  leaf_spring_z_offset = 5mm
  dl_tunnel_cpl = 5mm
  tunnel_z_offset = 2mm
  h_post_cpl = 7mm
geometry:
  Solid2 = imported_body(Z:\tcav\inventor\two_post_cylindrical_coupler\two_post_cylindrical_coupler_leaf_springs.stp)
  Solid2.rotate(axis=X, angle=90deg)
  Solid2.move(0mm, 0mm, z_shift)
  coupler_cavity [vacuum] = cylinder(axis=Z, base_centre=(0mm, 0mm, 0mm), radius=13mm, height=84.5mm)
  coupler_cavity.subtract(Solid2)
  chip [sapphire] = box(corner=(-w_chip/2, -l_chip/2, chip_zoffset-t_chip), size=(w_chip, l_chip, t_chip))
  chip_1 = chip.copy()
  coupler_cavity.subtract(chip_1)
  l_pad = rectangle(corner=(-w_chip/2, -w_pad/2, chip_zoffset), x_size=l_pad, y_size=w_pad)
  l_pad_taper = rectangle(corner=(-l_junc/2-l_taper, -w_junc/2, chip_zoffset), x_size=l_taper, y_size=w_junc)
  jj = rectangle(corner=(-w_junc/2, -l_junc/2, chip_zoffset), x_size=w_junc, y_size=l_junc)
  r_pad_taper = rectangle(corner=(l_junc/2, -w_junc/2, chip_zoffset), x_size=l_taper, y_size=w_junc)
  r_pad = rectangle(corner=(l_taper+ l_junc/2, -w_pad/2, chip_zoffset), x_size=l_pad, y_size=w_pad)
  cavity_ObjectFromFace1 = object_from(coupler_cavity.face(at (7.95616, 0, 5)))
  cavity_ObjectFromFace2 = object_from(coupler_cavity.face(at (6.68616, 6.5, 5)))
  cavity_ObjectFromFace3 = object_from(coupler_cavity.face(at (6.68616, -6.5, 5)))
  cavity_ObjectFromFace4 = object_from(coupler_cavity.face(at (-6.68616, 6.5, 5)))
  cavity_ObjectFromFace5 = object_from(coupler_cavity.face(at (-7.95616, 0, 5)))
  cavity_ObjectFromFace6 = object_from(coupler_cavity.face(at (-6.68616, -6.5, 5)))
  cavity_ObjectFromFace4_ObjectFromFace1 = object_from(cavity_ObjectFromFace4.face)
  cavity_ObjectFromEdge1 = object_from(coupler_cavity.edge(at (-1, 0, 5.5)))
  l_pad_ObjectFromEdge1..l_pad_ObjectFromEdge4 = object_from(l_pad.edge(all 4))
  cavity_ObjectFromEdge1.subtract(l_pad_ObjectFromEdge1..l_pad_ObjectFromEdge4)
  cavity_ObjectFromEdge2, cavity_ObjectFromEdge3 = object_from(coupler_cavity.edge(at (1.58579, 1.41421, 5.5), at (1.58579, -1.41421, 5.5)))
  r_pad_ObjectFromEdge1..r_pad_ObjectFromEdge4 = object_from(r_pad.edge(all 4))
  cavity_ObjectFromEdge2.unite(cavity_ObjectFromEdge3)
  cavity_ObjectFromEdge2.subtract(r_pad_ObjectFromEdge1..r_pad_ObjectFromEdge4)
  cavity_a = cylinder(axis=Z, base_centre=(-d_cpl_cav/2-d_cav_a/2-l_cpl_tunnel, 0mm, -(h_post_a-(h_post_cpl + leaf_spring_z_offset))), radius=d_cav_a/2, height=h_cav_a)
  cavity_b = cylinder(axis=Z, base_centre=(d_cpl_cav/2+d_cav_b/2+l_cpl_tunnel, 0mm, -(h_post_b-(h_post_cpl + leaf_spring_z_offset))), radius=d_cav_b/2, height=h_cav_b)
  cavity_a_post = cylinder(axis=Z, base_centre=(-d_cpl_cav/2-d_cav_a/2-l_cpl_tunnel, 0mm, -(h_post_a-(h_post_cpl + leaf_spring_z_offset))), radius=d_post_a/2, height=h_post_a)
  cavity_b_post = cylinder(axis=Z, base_centre=(d_cpl_cav/2+d_cav_b/2+l_cpl_tunnel, 0mm, -(h_post_b-(h_post_cpl + leaf_spring_z_offset))), radius=d_post_b/2, height=h_post_b)
  tunnel_cpl_a = cylinder(axis=X, base_centre=(-d_cpl_cav/2-l_cpl_tunnel-dl_tunnel_cpl/2, 0mm, max(h_post_a,h_post_b)+tunnel_z_offset), radius=d_cpl_tunnel/2, height=l_cpl_tunnel + dl_tunnel_cpl)
  tunnel_cpl_b = cylinder(axis=X, base_centre=(d_cpl_cav/2-dl_tunnel_cpl/2, 0mm, max(h_post_a,h_post_b)+tunnel_z_offset), radius=d_cpl_tunnel/2, height=l_cpl_tunnel + dl_tunnel_cpl)
  coupler_cavity.unite(cavity_b, cavity_a, tunnel_cpl_a, tunnel_cpl_b)
boundaries and excitations:
  pad_pec: Perfect E Objects=[l_pad, r_pad]
  taper_pec: Perfect E Objects=[l_pad_taper, r_pad_taper]
  LumpRLC1: Lumped RLC Objects=jj CurrentLine{(0.025, 0, 5.5) -> (-0.025, 0, 5.5)} RLC_Type=Parallel Inductance=LJ
  vac_imp: Impedance Faces=coupler_cavity.face(3 of 3) Resistance=377 Reactance=0
  Imped1: Impedance Faces=coupler_cavity.face(at (0, 6.5, 0), at (0, 0, 0), at (0, -6.5, 0)) Resistance=377 Reactance=0
  top_cav_vac: Impedance Faces=coupler_cavity.face(3 of 3, 3 of 3) Resistance=377 Reactance=0
mesh:
  chip_surface_mesh: LengthBased Faces=chip.face(+z) MaxLength=4*w_pad
  post_wall_mesh: LengthBased Faces=coupler_cavity.face(at (-1, 0, 9), at (5, 0, 9)) MaxLength=4*w_pad
  jj_mesh: LengthBased Objects=jj MaxLength=0.01mm
  taper_mesh: LengthBased Objects=[l_pad_taper, r_pad_taper] MaxLength=0.01mm
  pad_mesh: LengthBased Objects=[r_pad, l_pad] MaxLength=w_pad
  top_post_mesh: LengthBased Faces=coupler_cavity.face(at (3, 0, 12.5), at (-3, 0, 12.5)) MaxLength=0.8mm
  cavity_walls_mesh: LengthBased Faces=coupler_cavity.face(at (10, 0, 45), 3 of 3) MaxLength=15.8mm
setups:
  Setup1: HfssEigen MinimumFrequency=1.77515GHz NumModes=6 MaxDeltaFreq=0.05 ConvergeOnRealFreq=true MaximumPasses=30 MinimumPasses=1 MinimumConvergedPasses=1 PercentRefinement=30 BasisOrder=-1
source amplitudes:
  #-10:1: 1 0deg
  #-10:2..#-10:6: 0 0deg
optimetrics:
  LJ_sweep: Parametric Sim._Setups=[Setup1]
    sweep LJ: DEC 0.1nH 100nH 3
  LJ_crossing_refinement: Parametric Sim._Setups=[Setup1]
    sweep LJ: LIN 10nH 25nH 1nH
  dcpl_tunnel_sweep: Parametric Sim._Setups=[Setup1]
    sweep d_cpl_tunnel: LIN 2mm 10mm 2mm
  tunnel_z_offset_sweep: Parametric Sim._Setups=[Setup1]
    sweep tunnel_z_offset: LIN -6mm 4mm 2mm
  tunnel_length_sweep: Parametric Sim._Setups=[Setup1]
    sweep l_cpl_tunnel: LIN 2.25mm 3.75mm 0.25mm
field calculator expressions:
  UE_surf = Mag_E | 2 | Pow | EnterSurface(cavity_ObjectFromFace1) | SurfaceValue | Integrate | Mag_E | 2 | Pow | EnterSurface(cavity_ObjectFromFace2) | SurfaceValue | Integrate | + | Mag_E | 2 | Pow | EnterSurface(cavity_ObjectFromFace3) | SurfaceValue | Integrate | + | Mag_E | 2 | Pow | EnterSurface(cavity_ObjectFromFace4) | SurfaceValue | Integrate | + | Mag_E | 2 | Pow | EnterSurface(cavity_ObjectFromFace4_ObjectFromFace1) | SurfaceValue | Integrate | + | Mag_E | 2 | Pow | EnterSurface(cavity_ObjectFromFace5) | SurfaceValue | Integrate | + | Mag_E | 2 | Pow | EnterSurface(cavity_ObjectFromFace6) | SurfaceValue | Integrate | + | Scalar_Function(FuncValue='t_ox') | * | Scalar_Function(FuncValue='eps_al2o3') | *
  UE_sub = Mag_E | 2 | Pow | EnterVolume(chip) | VolumeValue | Integrate | 11.5 | *
  UH_tot = Mag_H | 2 | Pow | EnterVolume(AllObjects) | VolumeValue | Integrate
  UH_pads = Mag_H | 2 | Pow | EnterSurface(l_pad) | SurfaceValue | Integrate | Mag_H | 2 | Pow | EnterSurface(r_pad) | SurfaceValue | Integrate | + | Scalar_Function(FuncValue='lambdaL') | *
  pm_pads = UH_pads | UH_tot | /
  J_seams = Mag_Jsurf | 2 | Pow | EnterLine(cavity_ObjectFromEdge1) | LineValue | Integrate | Mag_Jsurf | 2 | Pow | EnterLine(cavity_ObjectFromEdge2) | LineValue | Integrate | +
  yseam = J_seams | UH_tot | /
  w0_mu0 = 7.89568352087149e-06 | Output_Variable(Freq, 4) | Real | *
  yseam_correct = J_seams | UH_tot | w0_mu0 | * | /
field plots:
  Vector_E1: E Field on Setup1 : LastAdaptive at Phase=0deg
reports:
  Calculator Expressions Plot 1: pe_surf, pe_sub vs LJ on Setup1 : LastAdaptive [Phase=0deg]
  Calculator Expressions Plot 2: pm_pads, pm_cav_walls vs LJ on Setup1 : LastAdaptive [Phase=90deg]
  Calculator Expressions Plot 6: yseam_correct vs LJ on Setup1 : LastAdaptive [Phase=90deg]
  Eigen Modes Plot 7: re(Mode(1)), re(Mode(2)), re(Mode(3)), re(Mode(4)), re(Mode(5)), re(Mode(6)) vs tunnel_z_offset on Setup1 : LastAdaptive [LJ=1nH l_cpl_tunnel=3mm d_cpl_tunnel=5mm]
  Eigen Q Plot 1: Q(1), Q(2), Q(3), Q(4), Q(5), Q(6) vs tunnel_z_offset on Setup1 : LastAdaptive [LJ=1nH l_cpl_tunnel=3mm d_cpl_tunnel=5mm]
  Mode splitting vs. tunnel z offset: re(Mode(2))-re(Mode(1)) vs tunnel_z_offset on Setup1 : LastAdaptive [LJ=1nH l_cpl_tunnel=3mm d_cpl_tunnel=5mm]
  Eigen Modes Plot 8: re(Mode(1)), re(Mode(2)), re(Mode(3)), re(Mode(4)), re(Mode(5)), re(Mode(6)) vs d_cpl_tunnel on Setup1 : LastAdaptive [LJ=1nH l_cpl_tunnel=3mm tunnel_z_offset=2mm]
  Mode splitting vs. tunnel diameter: re(Mode(2))-re(Mode(1)) vs d_cpl_tunnel on Setup1 : LastAdaptive [LJ=1nH l_cpl_tunnel=3mm tunnel_z_offset=2mm]
  Eigen Q Plot 2: Q(1), Q(2), Q(3), Q(4), Q(5), Q(6) vs d_cpl_tunnel on Setup1 : LastAdaptive [LJ=1nH l_cpl_tunnel=3mm tunnel_z_offset=2mm]
  Eigen Modes Plot 9: re(Mode(1)), re(Mode(2)), re(Mode(3)), re(Mode(4)), re(Mode(5)), re(Mode(6)) vs LJ on Setup1 : LastAdaptive [l_cpl_tunnel=3mm d_cpl_tunnel=6mm tunnel_z_offset=2mm]
   Plot 1: re(Mode(2))-re(Mode(1)) vs LJ on Setup1 : LastAdaptive [l_cpl_tunnel=3mm d_cpl_tunnel=6mm tunnel_z_offset=2mm]; markers m1 at 4.6415888nH, m2 at 1nH
