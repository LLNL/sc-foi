# Ansys Electronics Desktop project, version 2024.2
project variables:
  $r_cav = 10mm
  $d_walls = 3mm
  $l_cav = 84.5mm
  $air_bottom = 5mm
  $air_gap = 0.5mm
  $w_pad = 0.5mm
  $l_pad = 3.5mm
  $ysub_offset = 11.0276814mm
  $d_post = 4mm
  $l_taper = $w_sub/2-$l_pad-$l_junc/2
  $w_junc = 50um
  $l_junc = 50um
  $w_sub = 8mm
  $LJ = 10nH
materials:
  vacuum: permittivity=1
  sapphire: permittivity=10 dielectric_loss_tangent=1.9e-08
  pec: conductivity=1e+30

design two_post_no_jj (HFSS, Eigenmode, model units mm)
geometry:
  outer_cavity_body1, outer_cavity_body2, outer_cavity_body3 = imported_body(Z:\tcav\inventor\two_post_cylindrical_coupler\two_post_cylindrical_coupler.stp)
  substrate [sapphire] = imported_body(Z:\tcav\inventor\two_post_cylindrical_coupler\two_post_cylindrical_coupler.stp)
  brass_4_40_slotted_ball_nose_spring_plunger_body2, brass_4_40_slotted_ball_nose_spring_plunger_body2_1, brass_4_40_slotted_ball_nose_spring_plunger_body2_2, brass_4_40_slotted_ball_nose_spring_plunger_body2_3 = imported_body(Z:\tcav\inventor\two_post_cylindrical_coupler\two_post_cylindrical_coupler.stp)
  [outer_cavity_body1, outer_cavity_body2, outer_cavity_body3, substrate, brass_4_40_slotted_ball_nose_spring_plunger_body2, brass_4_40_slotted_ball_nose_spring_plunger_body2_1, brass_4_40_slotted_ball_nose_spring_plunger_body2_2, brass_4_40_slotted_ball_nose_spring_plunger_body2_3].move(39.248262mm, 55.188904mm, -4.1151374mm)
  [outer_cavity_body1, outer_cavity_body2, outer_cavity_body3, substrate, brass_4_40_slotted_ball_nose_spring_plunger_body2, brass_4_40_slotted_ball_nose_spring_plunger_body2_1, brass_4_40_slotted_ball_nose_spring_plunger_body2_2, brass_4_40_slotted_ball_nose_spring_plunger_body2_3].rotate(axis=X, angle=90deg)
  cylinder_stock [vacuum] = cylinder(axis=Z, base_centre=(0mm, -($r_cav + $d_walls), 0mm), radius=$r_cav + $d_walls, height=$l_cav)
  cylinder_stock.subtract(brass_4_40_slotted_ball_nose_spring_plunger_body2, brass_4_40_slotted_ball_nose_spring_plunger_body2_1, brass_4_40_slotted_ball_nose_spring_plunger_body2_2, brass_4_40_slotted_ball_nose_spring_plunger_body2_3, outer_cavity_body1, outer_cavity_body2, outer_cavity_body3)
  substrate_1 = substrate.copy()
  cylinder_stock.subtract(substrate_1)
  cylinder_stock_ObjectFromEdge1, cylinder_stock_ObjectFromEdge2, cylinder_stock_ObjectFromEdge3 = object_from(cylinder_stock.edge(at (2.79463, -11.9415, 5), at (2.79463, -14.0585, 5), at (-1.92177, -13, 5)))
  cylinder_stock_ObjectFromEdge4 = object_from(cylinder_stock.edge(at (5, -13, 5.5)))
  cylinder_stock_ObjectFromEdge5 = object_from(cylinder_stock.edge(at (-1, -13, 5.5)))
  group two_post_cylindrical_coupler = substrate
boundaries and excitations:
  TopVacuum: Impedance Faces=cylinder_stock.face(+z end) Resistance=377 Reactance=0
  ScrewHolesVacuum: Impedance Faces=cylinder_stock.face(at (3, -23.9822, 0), at (-3, -23.9822, 0), at (3, -13, 0), at (-3, -13, 0)) Resistance=377 Reactance=0
mesh:
  substrate_mesh: LengthBased RefineInside Objects=substrate MaxLength=2.8mm
  cavity_mesh: LengthBased RefineInside Objects=cylinder_stock MaxLength=16.9mm
setups:
  Setup1: HfssEigen MinimumFrequency=1.77515GHz NumModes=4 MaxDeltaFreq=1 ConvergeOnRealFreq=true MaximumPasses=30 MinimumPasses=1 MinimumConvergedPasses=1 PercentRefinement=30 BasisOrder=-1
source amplitudes:
  #-10:1: 1 0deg
  #-10:2, #-10:3, #-10:4: 0 0deg
field calculator expressions:
  H_int = Output_Variable(Freq, 4) | Mag_H | 2 | Pow | EnterVolume(AllObjects) | VolumeValue | Integrate | 1.25663706143592e-06 | * | * | 3.14159265358979 | * | 2 | *
  J1_int = Mag_Jvol | 2 | Pow | EnterLine(cylinder_stock_ObjectFromEdge1) | LineValue | Integrate
  J2_int = Mag_Jvol | 2 | Pow | EnterLine(cylinder_stock_ObjectFromEdge2) | LineValue | Integrate
  J3_int = Mag_Jvol | 2 | Pow | EnterLine(cylinder_stock_ObjectFromEdge3) | LineValue | Integrate
  J4_int = Mag_Jvol | 2 | Pow | EnterLine(cylinder_stock_ObjectFromEdge4) | LineValue | Integrate
  J5_int = Mag_Jvol | 2 | Pow | EnterLine(cylinder_stock_ObjectFromEdge5) | LineValue | Integrate
  y1seam = J1_int | H_int | /
  y2seam = J2_int | H_int | /
  y3seam = J3_int | H_int | /
  y4seam = J4_int | H_int | /
  y5seam = J5_int | H_int | /
field plots:
  Vector_E1: E Field on Setup1 : LastAdaptive at Phase=0deg
reports:
  Calculator Complex Expressions Table 1: re(y1seam), re(y2seam), re(y3seam), re(y4seam), re(y5seam), im(y1seam), im(y2seam), im(y3seam), im(y4seam), im(y5seam), re(H_int), im(H_int) vs Phase on Setup1 : LastAdaptive [Phase=90deg]

design two_post_jj (HFSS, Eigenmode, model units mm)
geometry:
  outer_cavity_body1, outer_cavity_body2, outer_cavity_body3 = imported_body(Z:\tcav\inventor\two_post_cylindrical_coupler\two_post_cylindrical_coupler.stp)
  substrate [sapphire] = imported_body(Z:\tcav\inventor\two_post_cylindrical_coupler\two_post_cylindrical_coupler.stp)
  brass_4_40_slotted_ball_nose_spring_plunger_body2, brass_4_40_slotted_ball_nose_spring_plunger_body2_1, brass_4_40_slotted_ball_nose_spring_plunger_body2_2, brass_4_40_slotted_ball_nose_spring_plunger_body2_3 = imported_body(Z:\tcav\inventor\two_post_cylindrical_coupler\two_post_cylindrical_coupler.stp)
  [outer_cavity_body1, outer_cavity_body2, outer_cavity_body3, substrate, brass_4_40_slotted_ball_nose_spring_plunger_body2, brass_4_40_slotted_ball_nose_spring_plunger_body2_1, brass_4_40_slotted_ball_nose_spring_plunger_body2_2, brass_4_40_slotted_ball_nose_spring_plunger_body2_3].move(39.248262mm, 55.188904mm, -4.1151374mm)
  [outer_cavity_body1, outer_cavity_body2, outer_cavity_body3, substrate, brass_4_40_slotted_ball_nose_spring_plunger_body2, brass_4_40_slotted_ball_nose_spring_plunger_body2_1, brass_4_40_slotted_ball_nose_spring_plunger_body2_2, brass_4_40_slotted_ball_nose_spring_plunger_body2_3].rotate(axis=X, angle=90deg)
  cylinder_stock [vacuum] = cylinder(axis=Z, base_centre=(0mm, -($r_cav + $d_walls), 0mm), radius=$r_cav + $d_walls, height=$l_cav)
  cylinder_stock.subtract(brass_4_40_slotted_ball_nose_spring_plunger_body2, brass_4_40_slotted_ball_nose_spring_plunger_body2_1, brass_4_40_slotted_ball_nose_spring_plunger_body2_2, brass_4_40_slotted_ball_nose_spring_plunger_body2_3, outer_cavity_body1, outer_cavity_body2, outer_cavity_body3)
  substrate_1 = substrate.copy()
  cylinder_stock.subtract(substrate_1)
  cylinder_stock_ObjectFromEdge1, cylinder_stock_ObjectFromEdge2, cylinder_stock_ObjectFromEdge3 = object_from(cylinder_stock.edge(at (2.79463, -11.9415, 5), at (2.79463, -14.0585, 5), at (-1.92177, -13, 5)))
  cylinder_stock_ObjectFromEdge4 = object_from(cylinder_stock.edge(at (5, -13, 5.5)))
  cylinder_stock_ObjectFromEdge5 = object_from(cylinder_stock.edge(at (-1, -13, 5.5)))
  bottom_pad = rectangle(corner=($d_post-$l_pad, -$ysub_offset-$d_post/2-$w_pad/2, $air_bottom+$air_gap), x_size=$l_pad, y_size=$w_pad)
  bottom_taper = rectangle(corner=($d_post-$l_pad-$l_taper, -$ysub_offset-$d_post/2-$w_junc/2, $air_bottom+$air_gap), x_size=$l_taper, y_size=$w_junc)
  jj = rectangle(corner=($d_post-$w_sub/2-$l_junc/2, -$ysub_offset-$d_post/2-$w_junc/2, $air_bottom+$air_gap), x_size=$l_junc, y_size=$w_junc)
  top_pad = rectangle(corner=(-$d_post, -$ysub_offset-$d_post/2-$w_pad/2, $air_bottom+$air_gap), x_size=$l_pad, y_size=$w_pad)
  top_taper = rectangle(corner=(-$d_post+$l_pad, -$ysub_offset-$d_post/2-$w_junc/2, $air_bottom+$air_gap), x_size=$l_taper, y_size=$w_junc)
  group two_post_cylindrical_coupler = substrate
boundaries and excitations:
  TopVacuum: Impedance Faces=cylinder_stock.face(+z end) Resistance=377 Reactance=0
  ScrewHolesVacuum: Impedance Faces=cylinder_stock.face(at (3, -23.9822, 0), at (-3, -23.9822, 0), at (3, -13, 0), at (-3, -13, 0)) Resistance=377 Reactance=0
  PerfE1: Perfect E Faces=bottom_pad.face bottom_taper.face top_taper.face top_pad.face
  LumpRLC1: Lumped RLC Faces=jj.face CurrentLine{(0.025, -13.0276814, 5.5) -> (-0.025, -13.0276814, 5.5)} RLC_Type=Parallel Inductance=$LJ
mesh:
  substrate_mesh: LengthBased RefineInside Objects=substrate MaxLength=2.8mm
  cavity_mesh: LengthBased RefineInside Objects=cylinder_stock MaxLength=16.9mm
  pad_mesh: LengthBased Objects=[bottom_pad, bottom_taper] MaxLength=$w_pad
  taper_mesh: LengthBased Objects=[top_pad, top_taper] MaxLength=$w_junc
  jj_mesh: LengthBased Objects=jj MaxLength=$w_junc
setups:
  Setup1: HfssEigen MinimumFrequency=1.77515GHz NumModes=4 MaxDeltaFreq=1 ConvergeOnRealFreq=true MaximumPasses=30 MinimumPasses=1 MinimumConvergedPasses=1 PercentRefinement=30 BasisOrder=-1
source amplitudes:
  #-10:1, #-10:3, #-10:4: 0 0deg
  #-10:2: 1 0deg
optimetrics:
  ParametricSetup1: Parametric Sim._Setups=[Setup1]
    sweep $LJ: DEC 0.1nH 100nH 3
field calculator expressions:
  H_int = Output_Variable(Freq, 4) | Mag_H | 2 | Pow | EnterVolume(AllObjects) | VolumeValue | Integrate | 1.25663706143592e-06 | * | * | 3.14159265358979 | * | 2 | *
  J1_int = Mag_Jvol | 2 | Pow | EnterLine(cylinder_stock_ObjectFromEdge1) | LineValue | Integrate
  J2_int = Mag_Jvol | 2 | Pow | EnterLine(cylinder_stock_ObjectFromEdge2) | LineValue | Integrate
  J3_int = Mag_Jvol | 2 | Pow | EnterLine(cylinder_stock_ObjectFromEdge3) | LineValue | Integrate
  J4_int = Mag_Jvol | 2 | Pow | EnterLine(cylinder_stock_ObjectFromEdge4) | LineValue | Integrate
  J5_int = Mag_Jvol | 2 | Pow | EnterLine(cylinder_stock_ObjectFromEdge5) | LineValue | Integrate
  y1seam = J1_int | H_int | /
  y2seam = J2_int | H_int | /
  y3seam = J3_int | H_int | /
  y4seam = J4_int | H_int | /
  y5seam = J5_int | H_int | /
  UE_vac = Mag_E | 2 | Pow | EnterVolume(cylinder_stock) | VolumeValue | Integrate | 8.854187817e-12 | * | 0.5 | *
  UE_sub = Mag_E | 2 | Pow | EnterVolume(substrate) | VolumeValue | Integrate | 10 | * | 8.854187817e-12 | * | 0.5 | *
  UE_tot = UE_vac | UE_sub | +
  pe_sub = UE_sub | UE_tot | /
  UH = Mag_H | 2 | Pow | EnterVolume(AllObjects) | VolumeValue | Integrate | 1.25663706143592e-06 | * | 0.5 | *
field plots:
  Vector_E1: E Field on Setup1 : LastAdaptive at Phase=0deg
  Vector_Jsurf1: Jsurf over jj.face on Setup1 : LastAdaptive at Phase=90deg
reports:
  Eigen Modes Plot 1: re(Mode(1)), re(Mode(2)), re(Mode(3)), re(Mode(4)) vs $LJ on Setup1 : LastAdaptive; markers m1 at 0.1nH, m2 at 100nH, m3 at 1nH, m4 at 10nH
  Eigen Q Plot 1: Q(1), Q(2), Q(3), Q(4) vs $LJ on Setup1 : LastAdaptive
  Calculator Expressions Plot 1: UE_sub, UE_tot, pe_sub vs $LJ on Setup1 : LastAdaptive [Phase=0deg]; UH vs $LJ on Setup1 : LastAdaptive [Phase=90deg]; markers m1 at 0.1nH, m2 at 100nH, m3 at 1nH, m4 at 10nH

design two_post_jj_bbq (HFSS, HFSS Modal Network, model units mm)
geometry:
  outer_cavity_body1, outer_cavity_body2, outer_cavity_body3 = imported_body(Z:\tcav\inventor\two_post_cylindrical_coupler\two_post_cylindrical_coupler.stp)
  substrate [sapphire] = imported_body(Z:\tcav\inventor\two_post_cylindrical_coupler\two_post_cylindrical_coupler.stp)
  brass_4_40_slotted_ball_nose_spring_plunger_body2, brass_4_40_slotted_ball_nose_spring_plunger_body2_1, brass_4_40_slotted_ball_nose_spring_plunger_body2_2, brass_4_40_slotted_ball_nose_spring_plunger_body2_3 = imported_body(Z:\tcav\inventor\two_post_cylindrical_coupler\two_post_cylindrical_coupler.stp)
  [outer_cavity_body1, outer_cavity_body2, outer_cavity_body3, substrate, brass_4_40_slotted_ball_nose_spring_plunger_body2, brass_4_40_slotted_ball_nose_spring_plunger_body2_1, brass_4_40_slotted_ball_nose_spring_plunger_body2_2, brass_4_40_slotted_ball_nose_spring_plunger_body2_3].move(39.248262mm, 55.188904mm, -4.1151374mm)
  [outer_cavity_body1, outer_cavity_body2, outer_cavity_body3, substrate, brass_4_40_slotted_ball_nose_spring_plunger_body2, brass_4_40_slotted_ball_nose_spring_plunger_body2_1, brass_4_40_slotted_ball_nose_spring_plunger_body2_2, brass_4_40_slotted_ball_nose_spring_plunger_body2_3].rotate(axis=X, angle=90deg)
  cylinder_stock [vacuum] = cylinder(axis=Z, base_centre=(0mm, -($r_cav + $d_walls), 0mm), radius=$r_cav + $d_walls, height=$l_cav)
  cylinder_stock.subtract(brass_4_40_slotted_ball_nose_spring_plunger_body2, brass_4_40_slotted_ball_nose_spring_plunger_body2_1, brass_4_40_slotted_ball_nose_spring_plunger_body2_2, brass_4_40_slotted_ball_nose_spring_plunger_body2_3, outer_cavity_body1, outer_cavity_body2, outer_cavity_body3)
  substrate_1 = substrate.copy()
  cylinder_stock.subtract(substrate_1)
  cylinder_stock_ObjectFromEdge1, cylinder_stock_ObjectFromEdge2, cylinder_stock_ObjectFromEdge3 = object_from(cylinder_stock.edge(at (2.79463, -11.9415, 5), at (2.79463, -14.0585, 5), at (-1.92177, -13, 5)))
  cylinder_stock_ObjectFromEdge4 = object_from(cylinder_stock.edge(at (5, -13, 5.5)))
  cylinder_stock_ObjectFromEdge5 = object_from(cylinder_stock.edge(at (-1, -13, 5.5)))
  bottom_pad = rectangle(corner=($d_post-$l_pad, -$ysub_offset-$d_post/2-$w_pad/2, $air_bottom+$air_gap), x_size=$l_pad, y_size=$w_pad)
  bottom_taper = rectangle(corner=($d_post-$l_pad-$l_taper, -$ysub_offset-$d_post/2-$w_junc/2, $air_bottom+$air_gap), x_size=$l_taper, y_size=$w_junc)
  jj = rectangle(corner=($d_post-$w_sub/2-$l_junc/2, -$ysub_offset-$d_post/2-$w_junc/2, $air_bottom+$air_gap), x_size=$l_junc, y_size=$w_junc)
  top_pad = rectangle(corner=(-$d_post, -$ysub_offset-$d_post/2-$w_pad/2, $air_bottom+$air_gap), x_size=$l_pad, y_size=$w_pad)
  top_taper = rectangle(corner=(-$d_post+$l_pad, -$ysub_offset-$d_post/2-$w_junc/2, $air_bottom+$air_gap), x_size=$l_taper, y_size=$w_junc)
  group two_post_cylindrical_coupler = substrate
boundaries and excitations:
  TopVacuum: Impedance Faces=cylinder_stock.face(+z end) Resistance=377 Reactance=0
  ScrewHolesVacuum: Impedance Faces=cylinder_stock.face(at (3, -23.9822, 0), at (-3, -23.9822, 0), at (3, -13, 0), at (-3, -13, 0)) Resistance=377 Reactance=0
  PerfE1: Perfect E Faces=bottom_pad.face bottom_taper.face top_taper.face top_pad.face
mesh:
  substrate_mesh: LengthBased RefineInside Objects=substrate MaxLength=2.8mm
  cavity_mesh: LengthBased RefineInside Objects=cylinder_stock MaxLength=16.9mm
  pad_mesh: LengthBased Objects=[bottom_pad, bottom_taper] MaxLength=$w_pad
  taper_mesh: LengthBased Objects=[top_pad, top_taper] MaxLength=$w_junc
  jj_mesh: LengthBased Objects=jj MaxLength=$w_junc
setups:
  Setup: HfssDriven Frequency=1GHz MaxDeltaE=0.1 MaximumPasses=10 MinimumPasses=1 MinimumConvergedPasses=1 PercentRefinement=30 BasisOrder=-1 DrivenSolverType="Direct Solver"
optimetrics:
  ParametricSetup1: Parametric
    sweep $LJ: DEC 0.1nH 100nH 3
field calculator expressions:
  H_int = Output_Variable(Freq, 4) | Mag_H | 2 | Pow | EnterVolume(AllObjects) | VolumeValue | Integrate | 1.25663706143592e-06 | * | * | 3.14159265358979 | * | 2 | *
  J1_int = Mag_Jvol | 2 | Pow | EnterLine(cylinder_stock_ObjectFromEdge1) | LineValue | Integrate
  J2_int = Mag_Jvol | 2 | Pow | EnterLine(cylinder_stock_ObjectFromEdge2) | LineValue | Integrate
  J3_int = Mag_Jvol | 2 | Pow | EnterLine(cylinder_stock_ObjectFromEdge3) | LineValue | Integrate
  J4_int = Mag_Jvol | 2 | Pow | EnterLine(cylinder_stock_ObjectFromEdge4) | LineValue | Integrate
  J5_int = Mag_Jvol | 2 | Pow | EnterLine(cylinder_stock_ObjectFromEdge5) | LineValue | Integrate
  y1seam = J1_int | H_int | /
  y2seam = J2_int | H_int | /
  y3seam = J3_int | H_int | /
  y4seam = J4_int | H_int | /
  y5seam = J5_int | H_int | /
  UE_vac = Mag_E | 2 | Pow | EnterVolume(cylinder_stock) | VolumeValue | Integrate | 8.854187817e-12 | * | 0.5 | *
  UE_sub = Mag_E | 2 | Pow | EnterVolume(substrate) | VolumeValue | Integrate | 10 | * | 8.854187817e-12 | * | 0.5 | *
  UE_tot = UE_vac | UE_sub | +
  pe_sub = UE_sub | UE_tot | /
  UH = Mag_H | 2 | Pow | EnterVolume(AllObjects) | VolumeValue | Integrate | 1.25663706143592e-06 | * | 0.5 | *
